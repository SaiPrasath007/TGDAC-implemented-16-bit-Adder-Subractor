// Design: cadence_project/xor_xnor_11t
simulator lang=spectre
global 0
include "/home/buet/cadence/gpdk180_v3.3/models/spectre/gpdk.scs" section=stat

// cadence_project/xor_xnor_11t/schematic
PM5 (net21 a vdc vdc) pmos1 w=(2u) l=180n m=(1)*(1)
PM4 (xnor b net21 vdc) pmos1 w=(2u) l=180n m=(1)*(1)
PM3 (xnor b\' a vdc) pmos1 w=(2u) l=180n m=(1)*(1)
PM2 (b\' b vdc vdc) pmos1 w=(2u) l=180n m=(1)*(1)
PM1 (b a xor vdc) pmos1 w=(2u) l=180n m=(1)*(1)
PM0 (a b xor vdc) pmos1 w=(2u) l=180n m=(1)*(1)
NM4 (xnor a b gnd) nmos1 w=(2u) l=180n m=(1)*(1)
NM3 (xnor b a gnd) nmos1 w=(2u) l=180n m=(1)*(1)
NM2 (b\' b gnd gnd) nmos1 w=(2u) l=180n m=(1)*(1)
NM1 (xor a b\' gnd) nmos1 w=(2u) l=180n m=(1)*(1)
NM0 (xor b\' a gnd) nmos1 w=(2u) l=180n m=(1)*(1)
V1 (vdc 0) vsource dc=1.8 type=dc
V3 (gnd 0) vsource dc=0 type=dc
V0 (a 0) vsource type=pulse val0=0 val1=1.8 period=10n rise=100.0p fall=100.0p width=5n
V2 (b 0) vsource type=pulse val0=0 val1=1.8 period=20n rise=100.0p fall=100.0p width=10n
simulatorOptions options temp=27
tran tran stop=100n errpreset=moderate
