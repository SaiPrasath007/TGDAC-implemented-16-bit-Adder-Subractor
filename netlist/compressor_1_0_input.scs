// Design: cadence_project/compressor_1_0
simulator lang=spectre
global 0
include "/home/buet/cadence/gpdk180_v3.3/models/spectre/gpdk.scs" section=stat

// cadence_project/compressor_1_0/schematic
PM9 (cin axnorb cout vdc) pmos1 w=(2u) l=180n m=(1)*(1)
PM8 (cout axorb a vdc) pmos1 w=(2u) l=180n m=(1)*(1)
PM7 (cin\' axnorb sum vdc) pmos1 w=(2u) l=180n m=(1)*(1)
PM6 (sum axorb cin vdc) pmos1 w=(2u) l=180n m=(1)*(1)
PM5 (cin cin\' vdc vdc) pmos1 w=(2u) l=180n m=(1)*(1)
PM4 (axnorb axorb vdc vdc) pmos1 w=(2u) l=180n m=(1)*(1)
PM3 (b\' a\' axorb vdc) pmos1 w=(2u) l=180n m=(1)*(1)
PM2 (axorb a b vdc) pmos1 w=(2u) l=180n m=(1)*(1)
PM1 (b\' b vdc vdc) pmos1 w=(2u) l=180n m=(1)*(1)
PM0 (a\' a vdc vdc) pmos1 w=(2u) l=180n m=(1)*(1)
NM9 (cout axorb cin gnd) nmos1 w=(2u) l=180n m=(1)*(1)
NM8 (a axnorb cout gnd) nmos1 w=(2u) l=180n m=(1)*(1)
NM7 (sum axorb cin\' gnd) nmos1 w=(2u) l=180n m=(1)*(1)
NM6 (cin axnorb sum gnd) nmos1 w=(2u) l=180n m=(1)*(1)
NM5 (cin cin\' gnd gnd) nmos1 w=(2u) l=180n m=(1)*(1)
NM4 (axnorb axorb gnd gnd) nmos1 w=(2u) l=180n m=(1)*(1)
NM3 (axorb a b\' gnd) nmos1 w=(2u) l=180n m=(1)*(1)
NM2 (b a\' axorb gnd) nmos1 w=(2u) l=180n m=(1)*(1)
NM1 (b\' b gnd gnd) nmos1 w=(2u) l=180n m=(1)*(1)
NM0 (a\' a gnd gnd) nmos1 w=(2u) l=180n m=(1)*(1)
simulatorOptions options temp=27
tran tran stop=100n errpreset=moderate
