// Design: cadence_project/compressor_0_1
simulator lang=spectre
global 0
include "/home/buet/cadence/gpdk180_v3.3/models/spectre/gpdk.scs" section=stat

// cadence_project/compressor_0_1/schematic
PM9 (cin\' axnorb cout\' net42) pmos1 w=(2u) l=180n m=(1)*(1)
PM8 (cout\' axorb a\' net44) pmos1 w=(2u) l=180n m=(1)*(1)
PM7 (cin\' axnorb sum net46) pmos1 w=(2u) l=180n m=(1)*(1)
PM6 (sum axorb cin net49) pmos1 w=(2u) l=180n m=(1)*(1)
PM5 (cin\' cin vdc vdc) pmos1 w=(2u) l=180n m=(1)*(1)
PM4 (axnorb axorb vdc vdc) pmos1 w=(2u) l=180n m=(1)*(1)
PM3 (b\' a\' axorb vdc) pmos1 w=(2u) l=180n m=(1)*(1)
PM2 (axorb a b vdc) pmos1 w=(2u) l=180n m=(1)*(1)
PM1 (b\' b vdc vdc) pmos1 w=(2u) l=180n m=(1)*(1)
PM0 (a\' a vdc vdc) pmos1 w=(2u) l=180n m=(1)*(1)
NM9 (cout\' axorb cin\' net43) nmos1 w=(2u) l=180n m=(1)*(1)
NM8 (a\' axnorb cout\' net45) nmos1 w=(2u) l=180n m=(1)*(1)
NM7 (sum axorb cin\' net47) nmos1 w=(2u) l=180n m=(1)*(1)
NM6 (cin axnorb sum net48) nmos1 w=(2u) l=180n m=(1)*(1)
NM5 (cin\' cin gnd gnd) nmos1 w=(2u) l=180n m=(1)*(1)
NM4 (axnorb axorb gnd gnd) nmos1 w=(2u) l=180n m=(1)*(1)
NM3 (axorb a b\' gnd) nmos1 w=(2u) l=180n m=(1)*(1)
NM2 (b a\' axorb gnd) nmos1 w=(2u) l=180n m=(1)*(1)
NM1 (b\' b gnd gnd) nmos1 w=(2u) l=180n m=(1)*(1)
NM0 (a\' a gnd gnd) nmos1 w=(2u) l=180n m=(1)*(1)
V1 (vdc 0) vsource dc=1.8 type=dc
V3 (gnd 0) vsource dc=0 type=dc
V0 (a 0) vsource type=pulse val0=0 val1=1.8 period=10n rise=100.0p fall=100.0p width=5n
V2 (b 0) vsource type=pulse val0=0 val1=1.8 period=20n rise=100.0p fall=100.0p width=10n
V4 (cin 0) vsource type=pulse val0=0 val1=1.8 period=40n rise=100.0p fall=100.0p width=20n
simulatorOptions options temp=27
tran tran stop=100n errpreset=moderate
