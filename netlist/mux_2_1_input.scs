// Design: cadence_project/mux_2_1
simulator lang=spectre
global 0
include "/home/buet/cadence/gpdk180_v3.3/models/spectre/gpdk.scs" section=stat

// cadence_project/mux_2_1/schematic
PM2 (s\' s vdc vdc) pmos1 w=(2u) l=180n m=(1)*(1)
PM0 (d1 s\' y vdc) pmos1 w=(2u) l=180n m=(1)*(1)
PM1 (y s d0 vdc) pmos1 w=(2u) l=180n m=(1)*(1)
NM2 (y s d1 gnd) nmos1 w=(2u) l=180n m=(1)*(1)
NM1 (d0 s\' y gnd) nmos1 w=(2u) l=180n m=(1)*(1)
NM0 (s\' s gnd gnd) nmos1 w=(2u) l=180n m=(1)*(1)
V6 (g 0) vsource dc=0 type=dc
V4 (v 0) vsource dc=1.8 type=dc
V2 (s 0) vsource type=pulse val0=0 val1=1.8V period=40n rise=100.0p fall=100.0p width=20n
V1 (d1 0) vsource type=pulse val0=0 val1=1.8V period=20n rise=100.0p fall=100.0p width=10n
V0 (d0 0) vsource type=pulse val0=0 val1=1.8V period=10n rise=100.0p fall=100.0p width=5n
simulatorOptions options temp=27
tran tran stop=100n errpreset=moderate
